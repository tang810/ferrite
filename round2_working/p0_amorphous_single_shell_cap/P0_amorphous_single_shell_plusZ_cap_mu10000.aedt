# Ansys Electronics Desktop project, version 2025.2
materials:
  vacuum: permittivity=1
  ferrite: permittivity=12 permeability=1000 conductivity=0.01
  copper: permeability=0.999991 conductivity=58000000
  p0_amorphous_mu10000: permeability=10000 conductivity=1

design Maxwell3DDesign1 (Maxwell 3D, Magnetostatic, model units mm)
variables:
  Rin = 100mm
  H = 200mm
  Iexc = 1mA
  a = 0.08mm
  g = 0mm
  T = 0.08mm
geometry:
  Cylinder1 = cylinder(axis=Z, base_centre=(0mm, 0mm, -H/2), radius=Rin, height=H)
  Cylinder2 [vacuum] = cylinder(axis=Z, base_centre=(0mm, 0mm, -H/2), radius=Rin+a, height=H)
  Cylinder2.subtract(Cylinder1)
  Torus1 [copper] = torus(axis=Z, centre=(0mm, 0mm, 0mm), major_radius=5mm, minor_radius=0.5mm)
  Torus1_Split1 [copper] = Torus1.split(plane=YZ, keep=Both)
  Torus1_Section1 [copper] = Torus1.section(plane=YZ)
  Torus1_Section1_Separate1 [copper] = Torus1_Section1.separate_bodies()
  Box1 [vacuum] = box(corner=(-400mm, -400mm, -400mm), size=(800mm, 800mm, 800mm))
  point BcenterPoint_0_0_0 = (0mm, 0mm, 0mm)
  point BcenterPoint_0_0_0_1 = (0mm, 0mm, 0mm)
  point BcenterPoint_0_0_0_2 = (0mm, 0mm, 0mm)
  point BcenterPoint_0_0_0_3 = (0, 0, 0)
  point BcenterPoint_0_0_0_4 = (0, 0, 0)
  P0_Amorphous_Shell [p0_amorphous_mu10000] = cylinder(axis=Z, base_centre=(0mm, 0mm, -100mm), radius=100.2mm, height=200mm)
  P0_Amorphous_Shell_inner_tool = cylinder(axis=Z, base_centre=(0mm, 0mm, -100mm), radius=100mm, height=200mm)
  P0_Amorphous_Shell.subtract(P0_Amorphous_Shell_inner_tool)
  P0_Amorphous_Cap_PlusZ [p0_amorphous_mu10000] = cylinder(axis=Z, base_centre=(0mm, 0mm, 100.03mm), radius=100.2mm, height=0.2mm)
boundaries and excitations:
  B0z_TH_67: Tangential H Field Faces=Box1.face(-x) ComponentXReal=1 ComponentYReal=0 CoordSysVector{(-400, 0, 0) -> (-400mm, 0mm, 10mm)}
  B0z_TH_69: Tangential H Field Faces=Box1.face(+x) ComponentXReal=1 ComponentYReal=0 CoordSysVector{(400, 0, 0) -> (400mm, 0mm, 10mm)}
  B0z_TH_66: Tangential H Field Faces=Box1.face(-y) ComponentXReal=1 ComponentYReal=0 CoordSysVector{(0, -400, 0) -> (0mm, -400mm, 10mm)}
  B0z_TH_68: Tangential H Field Faces=Box1.face(+y) ComponentXReal=1 ComponentYReal=0 CoordSysVector{(0, 400, 0) -> (0mm, 400mm, 10mm)}
  B0z_open_flux_faces: Zero Tangential H Field Faces=Box1.face(+z, -z)
mesh:
  Length_p0_amorphous_shell: LengthBased RefineInside Objects=P0_Amorphous_Shell NumMaxElem=5000 MaxLength=0.08mm
  Length_p0_amorphous_cap: LengthBased RefineInside Objects=P0_Amorphous_Cap_PlusZ NumMaxElem=5000 MaxLength=0.5mm
  initial mesh: GlobalCurvilinear{Apply}
setups:
  Setup1: Magnetostatic MaximumPasses=100 MinimumPasses=2 MinimumConvergedPasses=1 PercentRefinement=30 PercentError=1 NonLinearResidual=0.001
optimetrics:
  P_asweep1: Parametric Sim._Setups=[Setup1]
    sweep a: 0.5mm
    table edits: add(0.8mm) add(1.0mm) add(1.2mm) add(1.5mm) add(2.0mm)
    calculate IntH2_total on Setup1 : LastAdaptive
  P_Tcompare1: Parametric Sim._Setups=[Setup1]
    sweep T: 5mm
    table edits: add(8mm) add(10mm)
    calculate IntH2_total on Setup1 : LastAdaptive
field calculator expressions:
  IntH2_total = Mag_H | Mag_H | * | EnterVolume(Cylinder2) | VolumeValue | Integrate
field plots:
  Mag_H1, Mag_H2: H in Cylinder2 on Setup1 : LastAdaptive
  Mag_B1: B in Cylinder2 on Setup1 : LastAdaptive
reports:
  Calculator Expressions Table1: IntH2_total vs a on Setup1 : LastAdaptive [T=all]
  Calculator Expressions Table2: IntH2_total vs T on Setup1 : LastAdaptive [a=all]
  Calculator Expressions Table3: Mag_B vs Rin on Setup1 : LastAdaptive [a=all T=all]
