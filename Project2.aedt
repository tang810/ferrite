# Ansys Electronics Desktop project, version 2025.1
materials:
  copper: permeability=0.999991 conductivity=58000000
  ferrite: permittivity=12 permeability=1000 conductivity=0.01
  vacuum: permittivity=1

design Maxwell3DDesign2 (Maxwell 3D, Magnetostatic, model units mm)
geometry:
  Cylinder1 = cylinder(axis=Z, base_centre=(0mm, 0mm, -200mm), radius=200mm, height=400mm)
  Cylinder2 [ferrite] = cylinder(axis=Z, base_centre=(0mm, 0mm, -200mm), radius=201mm, height=400mm)
  Cylinder2.subtract(Cylinder1)
  Torus1 [copper] = torus(axis=Z, centre=(0mm, 0mm, 0mm), major_radius=5mm, minor_radius=0.5mm)
  Torus1_Split1 [copper] = Torus1.split(plane=YZ, keep=Both)
  Torus1_Section1 [copper] = Torus1.section(plane=YZ)
  Torus1_Section1_Separate1 [copper] = Torus1_Section1.separate_bodies()
  Box1 [vacuum] = box(corner=(-400mm, -400mm, -400mm), size=(800mm, 800mm, 800mm))
  Cylinder3 [ferrite] = cylinder(axis=Z, base_centre=(0mm, 0mm, 200mm), radius=200mm, height=1mm)
boundaries and excitations:
  Current1: Current Objects=Torus1_Section1 Current=1mA IsSolid=true Point_out_of_terminal=false
mesh:
  initial mesh: GlobalCurvilinear{Apply}
setups:
  Setup1: Magnetostatic MaximumPasses=100 MinimumPasses=2 MinimumConvergedPasses=1 PercentRefinement=30 PercentError=1 NonLinearResidual=0.001
field plots:
  Mag_H1, Mag_H2: H in Cylinder2 on Setup1 : LastAdaptive
  Mag_B1: B in Cylinder2 on Setup1 : LastAdaptive
  Mag_H3: H in Cylinder3 on Setup1 : LastAdaptive
