# Ansys Electronics Desktop project, version 2018.2
materials:
  vacuum: permittivity=1
  ferrite: permittivity=12 permeability=10000 conductivity=0.01
  permalloy: permeability=100000
  copper: permeability=0.999991 conductivity=58000000

design Magnetic noise_cubic (Maxwell 3D, Magnetostatic, model units mm)
variables:
  a = -30mm
  t = 18mm
geometry:
  Body [ferrite] = box(corner=(-120mm, -120mm, -87mm), size=(240mm, 240mm, 174mm))
  Bottom [ferrite] = box(corner=(-120mm, -120mm, -t/2), size=(240mm, 240mm, t))
  Cylinder2 = cylinder(axis=Z, base_centre=(0mm, 0mm, -25mm), radius=24.4mm, height=50mm)
  Bottom.subtract(Cylinder2)
  Cylinder3 = cylinder(axis=Z, base_centre=(0mm, 0mm, -200mm), radius=24.4mm, height=400mm)
  Body.subtract(Cylinder3)
  Cylinder4 = cylinder(axis=X, base_centre=(-150mm, 0mm, 0mm), radius=14.93mm, height=300mm)
  Body.subtract(Cylinder4)
  Cylinder5 = cylinder(axis=Y, base_centre=(0mm, -150mm, 0mm), radius=14.93mm, height=300mm)
  Body.subtract(Cylinder5)
  Bottom.move(0mm, 0mm, 87mm+t/2)
  Top [ferrite] = box(corner=(-120mm, -120mm, -t/2), size=(240mm, 240mm, t))
  Cylinder6 = cylinder(axis=Z, base_centre=(0mm, 0mm, -25mm), radius=24.4mm, height=50mm)
  Top.subtract(Cylinder6)
  Top.move(0mm, 0mm, -87mm-t/2)
  Box1 = box(corner=(t-120mm, t-120mm, -87mm), size=(240mm-2*t, 240mm-2*t, 174mm))
  Body.subtract(Box1)
  Box2 = box(corner=(-150mm, -5mm, 77mm), size=(300mm, 10mm, 10mm))
  Box2_1 = Box2.duplicate_along_line(step=(0mm, -45mm, 0mm), total=2)
  Box2_2 = Box2.duplicate_along_line(step=(0mm, 45mm, 0mm), total=2)
  Box2_3 = Box2.duplicate_along_line(step=(0mm, 0mm, -164mm), total=2)
  Box2_1_1 = Box2_1.duplicate_along_line(step=(0mm, 0mm, -164mm), total=2)
  Box2_2_1 = Box2_2.duplicate_along_line(step=(0mm, 0mm, -164mm), total=2)
  Box2_4 = Box2.duplicate_around_axis(axis=Z, angle=90deg, total=2)
  Box2_1_2 = Box2_1.duplicate_around_axis(axis=Z, angle=90deg, total=2)
  Box2_1_1_1 = Box2_1_1.duplicate_around_axis(axis=Z, angle=90deg, total=2)
  Box2_2_2 = Box2_2.duplicate_around_axis(axis=Z, angle=90deg, total=2)
  Box2_2_1_1 = Box2_2_1.duplicate_around_axis(axis=Z, angle=90deg, total=2)
  Box2_3_1 = Box2_3.duplicate_around_axis(axis=Z, angle=90deg, total=2)
  Body.subtract(Box2, Box2_1, Box2_1_1, Box2_1_1_1, Box2_1_2, Box2_2, Box2_2_1, Box2_2_1_1, Box2_2_2, Box2_3, Box2_3_1, Box2_4)
  Box3 [vacuum] = box(corner=(-800mm, -800mm, -800mm), size=(1600mm, 1600mm, 1600mm))
  y_axis [non-model] = polyline((0mm, -250mm, 0mm) (0mm, 250mm, 0mm))
  x_axis [non-model] = polyline((-250mm, 0mm, 0mm) (250mm, 0mm, 0mm))
  z_axis [non-model] = polyline((0mm, 0mm, -250mm) (0mm, 0mm, 250mm))
  D_x [non-model] = polyline((50mm, 0mm, 0mm) (-50mm, 0mm, 0mm))
  D_y [non-model] = polyline((0mm, 50mm, 0mm) (0mm, -50mm, 0mm))
  D_z [non-model] = polyline((0, 0, 50) (0mm, 0mm, -50mm))
  neicengkong, 2cengkong, 3cengkong, 4cengkong, 5cengkong, 6cengkong [permalloy] = imported_body(C:\Users\24455\Desktop\youkongzhuangpeiti.STEP)
  Rectangle1 [non-model] = rectangle(corner=(0mm, -200mm, -200mm), y_size=400mm, z_size=400mm)
  Torus1 [copper] = torus(axis=Z, centre=(0mm, 0mm, a), major_radius=5mm, minor_radius=0.5mm)
  Torus1_Section1 [copper] = Torus1.section(plane=YZ)
  Torus1_Section1.separate_bodies()
  group youkongzhuangpeiti = neicengkong, 2cengkong, 3cengkong, 4cengkong, 5cengkong, 6cengkong
  group Group1 = Body, Bottom, Top
boundaries and excitations:
  ZeroTangentialHField1: Zero Tangential H Field Faces=Box3.face(-y, +y)
  TangentialHField1: Tangential H Field Faces=Box3.face(+x) ComponentXReal=6 ComponentYReal=0 CoordSysVector{Box3.vertex(1 of 8) -> Box3.vertex(2 of 8)}
  TangentialHField2: Tangential H Field Faces=Box3.face(-x) ComponentXReal=6 ComponentYReal=0 CoordSysVector{Box3.vertex(4 of 8) -> Box3.vertex(3 of 8)}
  Current1: Current Objects=Torus1_Section1 Current=1A IsSolid=true Point_out_of_terminal=false
mesh:
  initial mesh: GlobalCurvilinear{Apply}
setups:
  Setup1: Magnetostatic MaximumPasses=10 MinimumPasses=2 MinimumConvergedPasses=1 PercentRefinement=30 PercentError=1 NonLinearResidual=0.001
optimetrics:
  ParametricSetup1: Parametric Sim._Setups=[Setup1]
    sweep a: LIN -40mm 40mm 10mm
    calculate abs(Squared_integrate_H_volume) on Setup1 : LastAdaptive
output variables:
  Noise = Squared_integrate_H_volume
field calculator expressions:
  Squared_integrate_H_volume = Fundamental_Quantity(21) | Fundamental_Quantity(21) | Dot | EnterVolume(Body) | VolumeValue | Integrate | Fundamental_Quantity(21) | Fundamental_Quantity(21) | Dot | EnterVolume(Top) | VolumeValue | Integrate | + | Fundamental_Quantity(21) | Fundamental_Quantity(21) | Dot | EnterVolume(Bottom) | VolumeValue | Integrate | +
reports:
  Calculator Expressions Plot 1: Squared_integrate_H_volume vs a on Setup1 : LastAdaptive

design Shielding factor_cubic (Maxwell 3D, Magnetostatic, model units mm)
variables:
  a = 0mm
  b = 0.1mm
  gap = [0, 0.05, 0.1, 0.15, 0.2, 0.25] mm
geometry:
  Body [ferrite] = box(corner=(-120mm, -120mm, -87mm), size=(240mm, 240mm, 174mm))
  Bottom [ferrite] = box(corner=(-120mm, -120mm, -18mm), size=(240mm, 240mm, 36mm))
  Cylinder2 = cylinder(axis=Z, base_centre=(0mm, 0mm, -25mm), radius=24.4mm, height=50mm)
  Bottom.subtract(Cylinder2)
  Cylinder3 = cylinder(axis=Z, base_centre=(0mm, 0mm, -200mm), radius=24.4mm, height=400mm)
  Body.subtract(Cylinder3)
  Cylinder4 = cylinder(axis=X, base_centre=(-150mm, 0mm, 0mm), radius=14.93mm, height=300mm)
  Body.subtract(Cylinder4)
  Cylinder5 = cylinder(axis=Y, base_centre=(0mm, -150mm, 0mm), radius=14.93mm, height=300mm)
  Body.subtract(Cylinder5)
  Bottom.move(0mm, 0mm, 105.1mm)
  Top [ferrite] = box(corner=(-120mm, -120mm, -18mm), size=(240mm, 240mm, 36mm))
  Cylinder6 = cylinder(axis=Z, base_centre=(0mm, 0mm, -25mm), radius=24.4mm, height=50mm)
  Top.subtract(Cylinder6)
  Top.move(0mm, 0mm, -105.1mm)
  Box1 = box(corner=(-84mm, -84mm, -87mm), size=(168mm, 168mm, 174mm))
  Body.subtract(Box1)
  Box2 = box(corner=(-150mm, -5mm, 77mm), size=(300mm, 10mm, 10mm))
  Box2_1 = Box2.duplicate_along_line(step=(0mm, -45mm, 0mm), total=2)
  Box2_2 = Box2.duplicate_along_line(step=(0mm, 45mm, 0mm), total=2)
  Box2_3 = Box2.duplicate_along_line(step=(0mm, 0mm, -164mm), total=2)
  Box2_1_1 = Box2_1.duplicate_along_line(step=(0mm, 0mm, -164mm), total=2)
  Box2_2_1 = Box2_2.duplicate_along_line(step=(0mm, 0mm, -164mm), total=2)
  Box2_4 = Box2.duplicate_around_axis(axis=Z, angle=90deg, total=2)
  Box2_1_2 = Box2_1.duplicate_around_axis(axis=Z, angle=90deg, total=2)
  Box2_1_1_1 = Box2_1_1.duplicate_around_axis(axis=Z, angle=90deg, total=2)
  Box2_2_2 = Box2_2.duplicate_around_axis(axis=Z, angle=90deg, total=2)
  Box2_2_1_1 = Box2_2_1.duplicate_around_axis(axis=Z, angle=90deg, total=2)
  Box2_3_1 = Box2_3.duplicate_around_axis(axis=Z, angle=90deg, total=2)
  Body.subtract(Box2, Box2_1, Box2_1_1, Box2_1_1_1, Box2_1_2, Box2_2, Box2_2_1, Box2_2_1_1, Box2_2_2, Box2_3, Box2_3_1, Box2_4)
  Box3 [vacuum] = box(corner=(-800mm, -800mm, -800mm), size=(1600mm, 1600mm, 1600mm))
  point Point1 = (0mm, 0mm, 0mm)
  D_x [non-model] = polyline((10mm, 0mm, 0mm) (-10mm, 0mm, 0mm))
  D_y [non-model] = polyline((0mm, 10mm, 0mm) (0mm, -10mm, 0mm))
  D_z [non-model] = polyline((0mm, 0mm, 10mm) (0mm, 0mm, -10mm))
  X1 [non-model] = rectangle(corner=(0mm, -200mm, -200mm), y_size=400mm, z_size=400mm)
  X2 [non-model] = rectangle(corner=(10mm, -200mm, -200mm), y_size=400mm, z_size=400mm)
  X3 [non-model] = rectangle(corner=(-10mm, -200mm, -200mm), y_size=400mm, z_size=400mm)
  D_x1 [non-model] = polyline((10mm, 10mm, 0mm) (-10mm, 10mm, 0mm))
  D_x2 [non-model] = polyline((10mm, -10mm, 0mm) (-10mm, -10mm, 0mm))
  Y1 [non-model] = rectangle(corner=(-200mm, 0mm, -200mm), z_size=400mm, x_size=400mm)
  Z1 [non-model] = rectangle(corner=(-200mm, -200mm, 0mm), x_size=400mm, y_size=400mm)
  group Group1 = Body, Bottom, Top
boundaries and excitations:
  ZeroTangentialHField2: Zero Tangential H Field Faces=Box3.face(+z, -z)
  TangentialHField3: Tangential H Field Faces=Box3.face(-x) ComponentXReal=0.5 ComponentYReal=0 CoordSysVector{Box3.vertex(3 of 8) -> Box3.vertex(8 of 8)}
  TangentialHField4: Tangential H Field Faces=Box3.face(+x) ComponentXReal=0.5 ComponentYReal=0 CoordSysVector{Box3.vertex(2 of 8) -> Box3.vertex(5 of 8)}
mesh:
  Length1: LengthBased Objects=[Body, Bottom, Top] NumMaxElem=2000 MaxLength=0.1mm
  initial mesh: GlobalSurfApproximation{CurvedSurfaceApproxChoice=UseSlider SliderMeshSettings=7} GlobalCurvilinear{Apply}
setups:
  Setup1: Magnetostatic MaximumPasses=10 MinimumPasses=2 MinimumConvergedPasses=1 PercentRefinement=30 PercentError=1 NonLinearResidual=0.001
field calculator expressions:
  Squared_integrate_H_volume = Fundamental_Quantity(21) | Fundamental_Quantity(21) | Dot | EnterVolume(Body) | VolumeValue | Integrate | Fundamental_Quantity(21) | Fundamental_Quantity(21) | Dot | EnterVolume(Top) | VolumeValue | Integrate | + | Fundamental_Quantity(21) | Fundamental_Quantity(21) | Dot | EnterVolume(Bottom) | VolumeValue | Integrate | +
field plots:
  Mag_B1, Mag_B4, Mag_B5: B over a plane on Setup1 : LastAdaptive
reports:
  Calculator Expressions Plot 1: Squared_integrate_H_volume vs a on Setup1 : LastAdaptive
  Calculator Expressions Table 1: abs(Mag_B) vs Distance on Setup1 : LastAdaptive
   Plot 1: abs(Mag_B), abs(Mag_B), abs(Mag_B) vs Distance on Setup1 : LastAdaptive
  Calculator Expressions Plot 2: Squared_integrate_H_volume vs a on Setup1 : LastAdaptive
   Table 1: abs(Mag_B), abs(Mag_B), abs(Mag_B) vs Distance on Setup1 : LastAdaptive

design Magnetic noise_cylinder (Maxwell 3D, Magnetostatic, model units mm)
variables:
  a = 0mm
  b = 0.1mm
  gap = [0, 0.05, 0.1, 0.15, 0.2, 0.25] mm
geometry:
  Box3 [vacuum] = box(corner=(-800mm, -800mm, -800mm), size=(1600mm, 1600mm, 1600mm))
  y_axis [non-model] = polyline((0mm, -250mm, 0mm) (0mm, 250mm, 0mm))
  x_axis [non-model] = polyline((-250mm, 0mm, 0mm) (250mm, 0mm, 0mm))
  z_axis [non-model] = polyline((0mm, 0mm, -250mm) (0mm, 0mm, 250mm))
  point Point1 = (0mm, 0mm, 0mm)
  D_x [non-model] = polyline((50mm, 0mm, 0mm) (-50mm, 0mm, 0mm))
  D_y [non-model] = polyline((0mm, 50mm, 0mm) (0mm, -50mm, 0mm))
  D_z [non-model] = polyline((0mm, 0mm, 50mm) (0mm, 0mm, -50mm))
  neicengkong, 2cengkong, 3cengkong, 4cengkong, 5cengkong, 6cengkong [permalloy] = imported_body(C:\Users\24455\Desktop\youkongzhuangpeiti.STEP)
  Rectangle1 [non-model] = rectangle(corner=(0mm, -200mm, -200mm), y_size=400mm, z_size=400mm)
  Torus1 [copper] = torus(axis=Z, centre=(0mm, 0mm, 0mm), major_radius=5mm, minor_radius=0.5mm)
  Torus1_Section1 [copper] = Torus1.section(plane=YZ)
  Torus1_Section1.separate_bodies()
  Cylinder1 [ferrite] = cylinder(axis=Z, base_centre=(0mm, 0mm, -123mm), radius=120mm, height=246mm)
  Cylinder2 = cylinder(axis=Z, base_centre=(0mm, 0mm, -87mm), radius=84mm, height=174mm)
  Cylinder1.subtract(Cylinder2)
  Cylinder3 = cylinder(axis=Z, base_centre=(0mm, 0mm, -150mm), radius=25mm, height=300mm)
  Cylinder1.subtract(Cylinder3)
  Cylinder4 = cylinder(axis=X, base_centre=(-150mm, 0mm, 0mm), radius=15mm, height=300mm)
  Cylinder1.subtract(Cylinder4)
  Cylinder5 = cylinder(axis=Y, base_centre=(0mm, -150mm, 0mm), radius=15mm, height=300mm)
  Cylinder1.subtract(Cylinder5)
  group youkongzhuangpeiti = neicengkong, 2cengkong, 3cengkong, 4cengkong, 5cengkong, 6cengkong
boundaries and excitations:
  ZeroTangentialHField1: Zero Tangential H Field Faces=Box3.face(-y, +y)
  TangentialHField1: Tangential H Field Faces=Box3.face(+x) ComponentXReal=6 ComponentYReal=0 CoordSysVector{Box3.vertex(1 of 8) -> Box3.vertex(2 of 8)}
  TangentialHField2: Tangential H Field Faces=Box3.face(-x) ComponentXReal=6 ComponentYReal=0 CoordSysVector{Box3.vertex(4 of 8) -> Box3.vertex(3 of 8)}
  Current1: Current Objects=Torus1_Section1 Current=1A IsSolid=true Point_out_of_terminal=false
mesh:
  initial mesh: GlobalCurvilinear{Apply}
setups:
  Setup1: Magnetostatic MaximumPasses=10 MinimumPasses=2 MinimumConvergedPasses=1 PercentRefinement=30 PercentError=1 NonLinearResidual=0.001
field calculator expressions:
  H_square = Fundamental_Quantity(21) | Fundamental_Quantity(21) | Dot | EnterVolume(Cylinder1) | VolumeValue | Integrate
reports:
   Table 2: abs(H_square) vs a on Setup1 : LastAdaptive

design Shielding factor_vaccum (Maxwell 3D, Magnetostatic, model units mm)
variables:
  a = 0mm
  b = 0.1mm
  gap = [0, 0.05, 0.1, 0.15, 0.2, 0.25] mm
geometry:
  Box3 [vacuum] = box(corner=(-800mm, -800mm, -800mm), size=(1600mm, 1600mm, 1600mm))
  point Point1 = (0mm, 0mm, 0mm)
  D_x [non-model] = polyline((20mm, 0mm, 0mm) (-20mm, 0mm, 0mm))
  D_y [non-model] = polyline((0mm, 20mm, 0mm) (0mm, -20mm, 0mm))
  D_z [non-model] = polyline((0mm, 0mm, 50mm) (0mm, 0mm, -50mm))
  X1 [non-model] = rectangle(corner=(0mm, -200mm, -200mm), y_size=400mm, z_size=400mm)
  X2 [non-model] = rectangle(corner=(10mm, -200mm, -200mm), y_size=400mm, z_size=400mm)
  X3 [non-model] = rectangle(corner=(-10mm, -200mm, -200mm), y_size=400mm, z_size=400mm)
  D_x1 [non-model] = polyline((10mm, 10mm, 0mm) (-10mm, 10mm, 0mm))
  D_x2 [non-model] = polyline((10mm, -10mm, 0mm) (-10mm, -10mm, 0mm))
  Y1 [non-model] = rectangle(corner=(-200mm, 0mm, -200mm), z_size=400mm, x_size=400mm)
  Z1 [non-model] = rectangle(corner=(-200mm, -200mm, 0mm), x_size=400mm, y_size=400mm)
boundaries and excitations:
  ZeroTangentialHField1: Zero Tangential H Field Faces=Box3.face(-y, +y)
  TangentialHField1: Tangential H Field Faces=Box3.face(+x) ComponentXReal=0.5 ComponentYReal=0 CoordSysVector{Box3.vertex(1 of 8) -> Box3.vertex(2 of 8)}
  TangentialHField2: Tangential H Field Faces=Box3.face(-x) ComponentXReal=0.5 ComponentYReal=0 CoordSysVector{Box3.vertex(4 of 8) -> Box3.vertex(3 of 8)}
mesh:
  initial mesh: GlobalCurvilinear{Apply}
setups:
  Setup1: Magnetostatic MaximumPasses=10 MinimumPasses=2 MinimumConvergedPasses=1 PercentRefinement=30 PercentError=1 NonLinearResidual=0.001
field plots:
  Mag_B1, Mag_B4, Mag_B5: B over a plane on Setup1 : LastAdaptive
reports:
  Calculator Expressions Plot 1: Squared_integrate_H_volume vs a on Setup1 : LastAdaptive
  Calculator Expressions Table 1: abs(Mag_B) vs Distance on Setup1 : LastAdaptive
   Plot 1: abs(Mag_B), abs(Mag_B), abs(Mag_B) vs Distance on Setup1 : LastAdaptive
   Table 2: abs(Mag_B) vs Distance on Setup1 : LastAdaptive
  Calculator Expressions Plot 2: Squared_integrate_H_volume vs a on Setup1 : LastAdaptive

design Magnetic noise_cubic_thickness (Maxwell 3D, Magnetostatic, model units mm)
variables:
  a = -30mm
  t = 30mm
geometry:
  Body [ferrite] = box(corner=(-120mm, -120mm, -87mm), size=(240mm, 240mm, 174mm))
  Bottom [ferrite] = box(corner=(-120mm, -120mm, -18mm), size=(240mm, 240mm, 36mm))
  Cylinder2 = cylinder(axis=Z, base_centre=(0mm, 0mm, -25mm), radius=24.4mm, height=50mm)
  Bottom.subtract(Cylinder2)
  Cylinder3 = cylinder(axis=Z, base_centre=(0mm, 0mm, -200mm), radius=24.4mm, height=400mm)
  Body.subtract(Cylinder3)
  Cylinder4 = cylinder(axis=X, base_centre=(-150mm, 0mm, 0mm), radius=14.93mm, height=300mm)
  Body.subtract(Cylinder4)
  Cylinder5 = cylinder(axis=Y, base_centre=(0mm, -150mm, 0mm), radius=14.93mm, height=300mm)
  Body.subtract(Cylinder5)
  Bottom.move(0mm, 0mm, 105mm)
  Top [ferrite] = box(corner=(-120mm, -120mm, -18mm), size=(240mm, 240mm, 36mm))
  Cylinder6 = cylinder(axis=Z, base_centre=(0mm, 0mm, -25mm), radius=24.4mm, height=50mm)
  Top.subtract(Cylinder6)
  Top.move(0mm, 0mm, -105mm)
  Box1 = box(corner=(t-120mm, t-120mm, -87mm), size=(240mm-2*t, 240mm-2*t, 174mm))
  Body.subtract(Box1)
  Box2 = box(corner=(-150mm, -5mm, 77mm), size=(300mm, 10mm, 10mm))
  Box2_1 = Box2.duplicate_along_line(step=(0mm, -45mm, 0mm), total=2)
  Box2_2 = Box2.duplicate_along_line(step=(0mm, 45mm, 0mm), total=2)
  Box2_3 = Box2.duplicate_along_line(step=(0mm, 0mm, -164mm), total=2)
  Box2_1_1 = Box2_1.duplicate_along_line(step=(0mm, 0mm, -164mm), total=2)
  Box2_2_1 = Box2_2.duplicate_along_line(step=(0mm, 0mm, -164mm), total=2)
  Box2_4 = Box2.duplicate_around_axis(axis=Z, angle=90deg, total=2)
  Box2_1_2 = Box2_1.duplicate_around_axis(axis=Z, angle=90deg, total=2)
  Box2_1_1_1 = Box2_1_1.duplicate_around_axis(axis=Z, angle=90deg, total=2)
  Box2_2_2 = Box2_2.duplicate_around_axis(axis=Z, angle=90deg, total=2)
  Box2_2_1_1 = Box2_2_1.duplicate_around_axis(axis=Z, angle=90deg, total=2)
  Box2_3_1 = Box2_3.duplicate_around_axis(axis=Z, angle=90deg, total=2)
  Body.subtract(Box2, Box2_1, Box2_1_1, Box2_1_1_1, Box2_1_2, Box2_2, Box2_2_1, Box2_2_1_1, Box2_2_2, Box2_3, Box2_3_1, Box2_4)
  Box3 [vacuum] = box(corner=(-800mm, -800mm, -800mm), size=(1600mm, 1600mm, 1600mm))
  y_axis [non-model] = polyline((0mm, -250mm, 0mm) (0mm, 250mm, 0mm))
  x_axis [non-model] = polyline((-250mm, 0mm, 0mm) (250mm, 0mm, 0mm))
  z_axis [non-model] = polyline((0mm, 0mm, -250mm) (0mm, 0mm, 250mm))
  D_x [non-model] = polyline((50mm, 0mm, 0mm) (-50mm, 0mm, 0mm))
  D_y [non-model] = polyline((0mm, 50mm, 0mm) (0mm, -50mm, 0mm))
  D_z [non-model] = polyline((0, 0, 50) (0mm, 0mm, -50mm))
  neicengkong, 2cengkong, 3cengkong, 4cengkong, 5cengkong, 6cengkong [permalloy] = imported_body(C:\Users\24455\Desktop\youkongzhuangpeiti.STEP)
  Rectangle1 [non-model] = rectangle(corner=(0mm, -200mm, -200mm), y_size=400mm, z_size=400mm)
  Torus1 [copper] = torus(axis=Y, centre=(0mm, 0mm, 0mm), major_radius=5mm, minor_radius=0.5mm)
  Torus1_Section1 [copper] = Torus1.section(plane=XY)
  Torus1_Section1.separate_bodies()
  group youkongzhuangpeiti = neicengkong, 2cengkong, 3cengkong, 4cengkong, 5cengkong, 6cengkong
  group Group1 = Body, Bottom, Top
boundaries and excitations:
  ZeroTangentialHField1: Zero Tangential H Field Faces=Box3.face(-y, +y)
  TangentialHField1: Tangential H Field Faces=Box3.face(+x) ComponentXReal=6 ComponentYReal=0 CoordSysVector{Box3.vertex(1 of 8) -> Box3.vertex(2 of 8)}
  TangentialHField2: Tangential H Field Faces=Box3.face(-x) ComponentXReal=6 ComponentYReal=0 CoordSysVector{Box3.vertex(4 of 8) -> Box3.vertex(3 of 8)}
  Current1: Current Objects=Torus1_Section1 Current=1A IsSolid=true Point_out_of_terminal=false
mesh:
  initial mesh: GlobalCurvilinear{Apply}
setups:
  Setup1: Magnetostatic MaximumPasses=10 MinimumPasses=2 MinimumConvergedPasses=1 PercentRefinement=30 PercentError=1 NonLinearResidual=0.001
optimetrics:
  ParametricSetup1: Parametric Sim._Setups=[Setup1]
    sweep t: LIN 18mm 54mm 3mm
    calculate abs(Squared_integrate_H_volume) on Setup1 : LastAdaptive
output variables:
  Noise = Squared_integrate_H_volume
field calculator expressions:
  Squared_integrate_H_volume = Fundamental_Quantity(21) | Fundamental_Quantity(21) | Dot | EnterVolume(Body) | VolumeValue | Integrate | Fundamental_Quantity(21) | Fundamental_Quantity(21) | Dot | EnterVolume(Top) | VolumeValue | Integrate | + | Fundamental_Quantity(21) | Fundamental_Quantity(21) | Dot | EnterVolume(Bottom) | VolumeValue | Integrate | +
reports:
  Calculator Expressions Plot 1: Squared_integrate_H_volume vs t on Setup1 : LastAdaptive [a=all]
  Calculator Expressions Plot 2: Squared_integrate_H_volume vs t on Setup1 : LastAdaptive

design Magnetic noise_cubic_thickness2 (Maxwell 3D, Magnetostatic, model units mm)
variables:
  a = -30mm
  t = 66mm
geometry:
  Body [ferrite] = box(corner=(-120mm, -120mm, -87mm), size=(240mm, 240mm, 174mm))
  Bottom [ferrite] = box(corner=(-120mm, -120mm, -t/2), size=(240mm, 240mm, t))
  Cylinder2 = cylinder(axis=Z, base_centre=(0mm, 0mm, -25mm), radius=24.4mm, height=50mm)
  Bottom.subtract(Cylinder2)
  Cylinder3 = cylinder(axis=Z, base_centre=(0mm, 0mm, -200mm), radius=24.4mm, height=400mm)
  Body.subtract(Cylinder3)
  Cylinder4 = cylinder(axis=X, base_centre=(-150mm, 0mm, 0mm), radius=14.93mm, height=300mm)
  Body.subtract(Cylinder4)
  Cylinder5 = cylinder(axis=Y, base_centre=(0mm, -150mm, 0mm), radius=14.93mm, height=300mm)
  Body.subtract(Cylinder5)
  Bottom.move(0mm, 0mm, 87.1mm+t/2)
  Top [ferrite] = box(corner=(-120mm, -120mm, -t/2), size=(240mm, 240mm, t))
  Cylinder6 = cylinder(axis=Z, base_centre=(0mm, 0mm, -25mm), radius=24.4mm, height=50mm)
  Top.subtract(Cylinder6)
  Top.move(0mm, 0mm, -87.1mm-t/2)
  Box1 = box(corner=(t-120mm, t-120mm, -87mm), size=(240mm-2*t, 240mm-2*t, 174mm))
  Body.subtract(Box1)
  Box2 = box(corner=(-150mm, -5mm, 77mm), size=(300mm, 10mm, 10mm))
  Box2_1 = Box2.duplicate_along_line(step=(0mm, -45mm, 0mm), total=2)
  Box2_2 = Box2.duplicate_along_line(step=(0mm, 45mm, 0mm), total=2)
  Box2_3 = Box2.duplicate_along_line(step=(0mm, 0mm, -164mm), total=2)
  Box2_1_1 = Box2_1.duplicate_along_line(step=(0mm, 0mm, -164mm), total=2)
  Box2_2_1 = Box2_2.duplicate_along_line(step=(0mm, 0mm, -164mm), total=2)
  Box2_4 = Box2.duplicate_around_axis(axis=Z, angle=90deg, total=2)
  Box2_1_2 = Box2_1.duplicate_around_axis(axis=Z, angle=90deg, total=2)
  Box2_1_1_1 = Box2_1_1.duplicate_around_axis(axis=Z, angle=90deg, total=2)
  Box2_2_2 = Box2_2.duplicate_around_axis(axis=Z, angle=90deg, total=2)
  Box2_2_1_1 = Box2_2_1.duplicate_around_axis(axis=Z, angle=90deg, total=2)
  Box2_3_1 = Box2_3.duplicate_around_axis(axis=Z, angle=90deg, total=2)
  Body.subtract(Box2, Box2_1, Box2_1_1, Box2_1_1_1, Box2_1_2, Box2_2, Box2_2_1, Box2_2_1_1, Box2_2_2, Box2_3, Box2_3_1, Box2_4)
  Box3 [vacuum] = box(corner=(-800mm, -800mm, -800mm), size=(1600mm, 1600mm, 1600mm))
  y_axis [non-model] = polyline((0mm, -250mm, 0mm) (0mm, 250mm, 0mm))
  x_axis [non-model] = polyline((-250mm, 0mm, 0mm) (250mm, 0mm, 0mm))
  z_axis [non-model] = polyline((0mm, 0mm, -250mm) (0mm, 0mm, 250mm))
  D_x [non-model] = polyline((50mm, 0mm, 0mm) (-50mm, 0mm, 0mm))
  D_y [non-model] = polyline((0mm, 50mm, 0mm) (0mm, -50mm, 0mm))
  D_z [non-model] = polyline((0, 0, 50) (0mm, 0mm, -50mm))
  neicengkong, 2cengkong, 3cengkong, 4cengkong, 5cengkong, 6cengkong [permalloy] = imported_body(C:\Users\24455\Desktop\youkongzhuangpeiti.STEP)
  Rectangle1 [non-model] = rectangle(corner=(0mm, -200mm, -200mm), y_size=400mm, z_size=400mm)
  Torus1 [copper] = torus(axis=Z, centre=(0mm, 0mm, 0mm), major_radius=5mm, minor_radius=0.5mm)
  Torus1_Section1 [copper] = Torus1.section(plane=YZ)
  Torus1_Section1.separate_bodies()
  group youkongzhuangpeiti = neicengkong, 2cengkong, 3cengkong, 4cengkong, 5cengkong, 6cengkong
  group Group1 = Body, Bottom, Top
boundaries and excitations:
  ZeroTangentialHField1: Zero Tangential H Field Faces=Box3.face(-y, +y)
  TangentialHField1: Tangential H Field Faces=Box3.face(+x) ComponentXReal=6 ComponentYReal=0 CoordSysVector{Box3.vertex(1 of 8) -> Box3.vertex(2 of 8)}
  TangentialHField2: Tangential H Field Faces=Box3.face(-x) ComponentXReal=6 ComponentYReal=0 CoordSysVector{Box3.vertex(4 of 8) -> Box3.vertex(3 of 8)}
  Current1: Current Objects=Torus1_Section1 Current=1A IsSolid=true Point_out_of_terminal=false
mesh:
  initial mesh: GlobalCurvilinear{Apply}
setups:
  Setup1: Magnetostatic MaximumPasses=10 MinimumPasses=2 MinimumConvergedPasses=1 PercentRefinement=30 PercentError=1 NonLinearResidual=0.001
output variables:
  Noise = Squared_integrate_H_volume
field calculator expressions:
  Squared_integrate_H_volume = Fundamental_Quantity(21) | Fundamental_Quantity(21) | Dot | EnterVolume(Body) | VolumeValue | Integrate | Fundamental_Quantity(21) | Fundamental_Quantity(21) | Dot | EnterVolume(Top) | VolumeValue | Integrate | + | Fundamental_Quantity(21) | Fundamental_Quantity(21) | Dot | EnterVolume(Bottom) | VolumeValue | Integrate | +
reports:
  Calculator Expressions Table 1: Squared_integrate_H_volume vs t on Setup1 : LastAdaptive
  Calculator Expressions Table 2: Squared_integrate_H_volume vs t on Setup1 : LastAdaptive
